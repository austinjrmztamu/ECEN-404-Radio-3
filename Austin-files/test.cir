** Profile: "SCHEMATIC1-test"  [ C:\Users\austi\AppData\Roaming\SPB_Data\cdssetup\workspace\projects\power distribution system\power distribution system-pspicefiles\schematic1\test.sim ]

** Creating circuit file "test.cir"
** WARNING: THIS AUTOMATICALLY GENERATED FILE MAY BE OVERWRITTEN BY SUBSEQUENT SIMULATIONS

*Libraries:
* Profile Libraries :
* Local Libraries :
.LIB "../../../power distribution system-pspicefiles/power distribution system.lib"
* From [PSPICE NETLIST] section of C:\Users\austi\AppData\Roaming\SPB_Data\cdssetup\OrCAD_PSpice\25.1.0\PSpice.ini file:
.lib "C:\Users\austi\OneDrive\Documents\College\ECEN 403\Cadence Library\TPS5420_PSPICE_TRANS\TPS5420_TRANS.LIB"
.lib "nom.lib"

*Analysis directives:
.TRAN  0 10m 0 50n
.OPTIONS ADVCONV
.PROBE64 V(alias(*)) I(alias(*)) W(alias(*)) D(alias(*)) NOISE(alias(*))
.INC "..\SCHEMATIC1.net"

.END
